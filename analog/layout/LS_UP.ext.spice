* NGSPICE file created from LS_UP.ext - technology: sky130A

.subckt LS_UP_LS_CORE VSS IN INB OUT VDDH
X0 VSS INB a_1015_259# VSS sky130_fd_pr__nfet_g5v0d10v5 ad=1.74 pd=12.58 as=1.74 ps=12.58 w=6 l=0.5
X1 VDDH a_373_259# OUT VDDH sky130_fd_pr__pfet_g5v0d10v5 ad=0.58 pd=4.58 as=0.58 ps=4.58 w=2 l=0.5
X2 VSS a_373_259# OUT VSS sky130_fd_pr__nfet_g5v0d10v5 ad=0.29 pd=2.58 as=0.29 ps=2.58 w=1 l=0.5
X3 VDDH a_373_259# a_1015_259# VDDH sky130_fd_pr__pfet_g5v0d10v5 ad=0.145 pd=1.58 as=0.145 ps=1.58 w=0.5 l=0.5
X4 VDDH a_1015_259# a_373_259# VDDH sky130_fd_pr__pfet_g5v0d10v5 ad=0.145 pd=1.58 as=0.145 ps=1.58 w=0.5 l=0.5
X5 VSS IN a_373_259# VSS sky130_fd_pr__nfet_g5v0d10v5 ad=1.74 pd=12.58 as=1.74 ps=12.58 w=6 l=0.5
.ends

.subckt LS_UP_LS_IN VSS INB IN VDDL
X0 VDDL IN INB VDDL sky130_fd_pr__pfet_g5v0d10v5 ad=0.29 pd=2.58 as=0.29 ps=2.58 w=1 l=0.5
X1 VSS IN INB VSS sky130_fd_pr__nfet_g5v0d10v5 ad=0.145 pd=1.58 as=0.145 ps=1.58 w=0.5 l=0.5
.ends

.subckt LS_UP IN VDDL VSS OUT VDDH
XXC VSS IN XI/INB OUT VDDH LS_UP_LS_CORE
XXI VSS XI/INB IN VDDL LS_UP_LS_IN
.ends
