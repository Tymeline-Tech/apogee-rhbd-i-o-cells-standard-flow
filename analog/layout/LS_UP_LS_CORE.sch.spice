.subckt LS_UP_LS_CORE IN INB OUT VDDH VSS
XMN1 X IN VSS VSS sky130_fd_pr__nfet_g5v0d10v5 L=0.5 W=6 nf=1
XMN2 Y INB VSS VSS sky130_fd_pr__nfet_g5v0d10v5 L=0.5 W=6 nf=1
XMP1 X Y VDDH VDDH sky130_fd_pr__pfet_g5v0d10v5 L=0.5 W=0.5 nf=1
XMP2 Y X VDDH VDDH sky130_fd_pr__pfet_g5v0d10v5 L=0.5 W=0.5 nf=1
XMPO OUT X VDDH VDDH sky130_fd_pr__pfet_g5v0d10v5 L=0.5 W=2 nf=1
XMNO OUT X VSS VSS sky130_fd_pr__nfet_g5v0d10v5 L=0.5 W=1 nf=1
.ends
