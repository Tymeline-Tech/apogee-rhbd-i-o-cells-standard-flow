.subckt CS_OUT_CS_OUT_DRV PGI NG PAD NW VDD VSS
MPO PAD PG VDD NW pch W=4 L=0.5 nf=4
MNO PAD NG VSS VSS nch W=2 L=0.5 nf=4
MW1 NW PAD VDD NW pch W=1 L=0.5
MW2 NW VDD PAD NW pch W=1 L=0.5
MT PG VDD PAD NW pch W=1 L=0.5
MNP PG VDD PGI VSS nch W=1 L=0.5
MPP PG PAD PGI NW pch W=1 L=0.5
.ends
