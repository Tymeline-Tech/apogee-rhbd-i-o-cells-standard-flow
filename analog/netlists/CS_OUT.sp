.subckt CS_OUT IN PAD VDD VSS OE
XPRE IN OE PGI NG VDD VSS CS_OUT_CS_OUT_PRE
XDRV PGI NG PAD NW VDD VSS CS_OUT_CS_OUT_DRV
.ends
